* Matriz completa

.inc SiDR140DP_PS.LIB

.MODEL MMBT2222A  NPN (IS=25.4f NF=1.00 BF=274 VAF=114
+ IKF=0.121 ISE=14.3p NE=2.00 BR=4.00 NR=1.00
+ VAR=24.0 IKR=0.300 RE=0.219 RB=0.877 RC=87.7m
+ XTB=1.5 CJE=27.6p VJE=1.10 MJE=0.500 CJC=14.2p VJC=0.300
+ MJC=0.300 TF=622p TR=124n EG=1.12 )
.MODEL MMBT2907A  PNP (IS=60.7f NF=1.00 BF=312 VAF=139
+ IKF=0.219 ISE=26.0p NE=2.00 BR=4.00 NR=1.00
+ VAR=20.0 IKR=0.540 RE=85.8m RB=0.343 RC=34.3m
+ XTB=1.5 CJE=50.4p VJE=1.10 MJE=0.500 CJC=23.1p VJC=0.300
+ MJC=0.300 TF=758p TR=123n EG=1.12 )

Q11_3 N029 N031 0 0 MMBT2222A
R11_5 N027 N029 300k
R11_4 N021 N027 49.9k
Q11_1 N023 N025 0 0 MMBT2222A
R11_3 N019 N023 1Meg
R11_2 N018 N019 10Meg
R11_6 N031 VcOFF 20k
Vcell11 N018 0 3.3
Q11_2 N021 N019 N018 0 MMBT2907A
X11 out_neg N027 0 SiDR140DP
Q12_3 N030 N032 0 0 MMBT2222A
R12_5 N028 N030 300k
R12_4 N022 N028 49.9k
Q12_1 N024 N026 0 0 MMBT2222A
R12_3 N020 N024 1Meg
R12_2 out_1 N020 10Meg
R12_6 N032 VcOFF 20k
Vcell12 out_1 0 3.3
Q12_2 N022 N020 out_1 0 MMBT2907A
X12 out_neg N028 0 SiDR140DP
Q21_3 N014 N016 0 0 MMBT2222A
R21_5 N012 N014 300k
R21_4 N004 N012 49.9k
Q21_1 N006 N008 0 0 MMBT2222A
R21_3 N002 N006 1Meg
R21_2 N001 N002 10Meg
R21_6 N016 VcOFF 20k
Vcell21 N001 N010 3.3
Q21_2 N004 N002 N001 0 MMBT2907A
X21 N018 N012 N010 SiDR140DP
Q22_3 N015 N017 0 0 MMBT2222A
R22_5 N013 N015 300k
R22_4 N005 N013 49.9k
Q22_1 N007 N009 0 0 MMBT2222A
R22_3 N003 N007 1Meg
R22_2 out_pos N003 10Meg
R22_6 N017 VcMENOS 20k
Vcell22 out_pos N011 3.3
Q22_2 N005 N003 out_pos 0 MMBT2907A
X22 out_1 N013 N011 SiDR140DP
Vcontrol1 VcMAS 0 PULSE(0 5 0 1p 1p 10m 20m)
Vcontrol2 VcMENOS 0 PULSE(0 5 10m 1p 1p 10m 20m)
Voff VcOFF 0 0
Von VcON 0 5
R11_1 N025 VcON 20k
R21_1 N008 VcON 20k
R22_1 N009 VcMAS 20k
R12_1 N026 VcON 20k
RL out_pos out_neg 1k
Rout1 out_1 N018 1m
Rout2 out_pos N001 1m
R1 0 N025 1m

.tran 0 40m 0 10u

.print tran V(out_pos, out_neg) I(RL) I(Vcell11) I(Vcell12) I(Vcell21) I(Vcell22)

.end
