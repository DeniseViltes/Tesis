*Netlist Matriz 5x5 con JFETs

* Subcircuitos externos y modelos:

* N-MOSFET:
.inc AO3401A.sub

* P-MOSFET:
.inc IRLB8721.sub

* TBJ NPN:
.MODEL MMBT2222A  NPN (IS=25.4f NF=1.00 BF=274 VAF=114 IKF=0.121 ISE=14.3p NE=2.00 BR=4.00 NR=1.00 VAR=24.0 IKR=0.300 RE=0.219 RB=0.877 RC=87.7m XTB=1.5 CJE=27.6p VJE=1.10 MJE=0.500 CJC=14.2p VJC=0.300 MJC=0.300 TF=622p TR=124n EG=1.12)

* TBJ PNP:
.MODEL MMBT2907A  PNP (IS=60.7f NF=1.00 BF=312 VAF=139 IKF=0.219 ISE=26.0p NE=2.00 BR=4.00 NR=1.00 VAR=20.0 IKR=0.540 RE=85.8m RB=0.343 RC=34.3m XTB=1.5 CJE=50.4p VJE=1.10 MJE=0.500 CJC=23.1p VJC=0.300 MJC=0.300 TF=758p TR=123n EG=1.12)

* N-JFET:
*.model MMBFJ201 NJF (level=2 beta=0.000896662032662677 is=3e-12 vto=-0.7942688438190106 delta=0.01 ibd=1.2446786457947927e-15 lambda=0.020523578895410437 lfgam=0.0021458335280504057 lfg1=0.005559062987986806 lfg2=0.0003231192453924478 mvst=0.0000010001509108580035 mxi=153.18973463472332 n=30 p=2.126477686276219 q=2.0772092809108735 rd=0.001 rs=0.0013024536946525222 vbd=56.68319057640032 vbi=9.95066604002855 vst=0.05701116820452227 xi=0.0000010307571946963999 z=1.1391767735628038 acgam=0 cds=0 cgd=0 cgs=0 fc=0.5 hfeta=0 hfe1=0 hfe2=0 hfgam=0 hfg1=0 hfg2=0 taud=0 taug=0 xc=0 af=1 kf=0)
.model MMBFJ201 NJF(Level=1 BETA=0.000896662 VTO=-0.7942688 LAMBDA=0.0205236 RD=0.001 RS=0.00130245 IS=3e-12 CGS=1p CGD=1p PB=1 FC=0.5)

* Fuentes de control:

* PULSE(0 5 0 1p 1p 10m 20m); sintaxis del pulso

VcBanco1 Vc1 0 0
VcBanco2 Vc2 0 0
VcBanco3 Vc3 0 0
VcBanco4 Vc4 0 0
VcBanco5 Vc5 0 0

* Fuentes Negadas

BV51_Negada Vc51_neg 0 V={5-V(Vc51_pos)}
BV52_Negada Vc52_neg 0 V={5-V(Vc52_pos)}
BV53_Negada Vc53_neg 0 V={5-V(Vc53_pos)}
BV54_Negada Vc54_neg 0 V={5-V(Vc54_pos)}
BV55_Negada Vc55_neg 0 V={5-V(Vc55_pos)}

BV41_Negada Vc41_neg 0 V={5-V(Vc41_pos)}
BV42_Negada Vc42_neg 0 V={5-V(Vc42_pos)}
BV43_Negada Vc43_neg 0 V={5-V(Vc43_pos)}
BV44_Negada Vc44_neg 0 V={5-V(Vc44_pos)}
BV45_Negada Vc45_neg 0 V={5-V(Vc45_pos)}

BV31_Negada Vc31_neg 0 V={5-V(Vc31_pos)}
BV32_Negada Vc32_neg 0 V={5-V(Vc32_pos)}
BV33_Negada Vc33_neg 0 V={5-V(Vc33_pos)}
BV34_Negada Vc34_neg 0 V={5-V(Vc34_pos)}
BV35_Negada Vc35_neg 0 V={5-V(Vc35_pos)}

BV21_Negada Vc21_neg 0 V={5-V(Vc21_pos)}
BV22_Negada Vc22_neg 0 V={5-V(Vc22_pos)}
BV23_Negada Vc23_neg 0 V={5-V(Vc23_pos)}
BV24_Negada Vc24_neg 0 V={5-V(Vc24_pos)}
BV25_Negada Vc25_neg 0 V={5-V(Vc25_pos)}

BV11_Negada Vc11_neg 0 V={5-V(Vc11_pos)}
BV12_Negada Vc12_neg 0 V={5-V(Vc12_pos)}
BV13_Negada Vc13_neg 0 V={5-V(Vc13_pos)}
BV14_Negada Vc14_neg 0 V={5-V(Vc14_pos)}
BV15_Negada Vc15_neg 0 V={5-V(Vc15_pos)}

* Entradas:

* Banco 1:
R11_1 N215 Vc11_pos 20k
R11_6 N231 Vc11_neg 20k
R12_1 N216 Vc12_pos 20k
R12_6 N232 Vc12_neg 20k
R13_1 N217 Vc13_pos 20k
R13_6 N233 Vc13_neg 20k
R14_1 N218 Vc14_pos 20k
R14_6 N234 Vc14_neg 20k
R15_1 N219 Vc15_pos 20k
R15_6 N235 Vc15_neg 20k
R1_9 N230 Vc1 20k

* Banco 2:
R21_1 N166 Vc21_pos 20k
R21_6 N187 Vc21_neg 20k
R22_1 N167 Vc22_pos 20k
R22_6 N188 Vc22_neg 20k
R23_1 N168 Vc23_pos 20k
R23_6 N189 Vc23_neg 20k
R24_1 N169 Vc24_pos 20k
R24_6 N190 Vc24_neg 20k
R25_1 N170 Vc25_pos 20k
R25_6 N191 Vc25_neg 20k
R2_9 N192 Vc2 20k

* Banco 3:
R31_1 N118 Vc31_pos 20k
R31_6 N139 Vc31_neg 20k
R32_1 N119 Vc32_pos 20k
R32_6 N140 Vc32_neg 20k
R33_1 N120 Vc33_pos 20k
R33_6 N141 Vc33_neg 20k
R34_1 N121 Vc34_pos 20k
R34_6 N142 Vc34_neg 20k
R35_1 N122 Vc35_pos 20k
R35_6 N143 Vc35_neg 20k
R3_9 N144 Vc3 20k

* Banco 4:
R41_1 N070 Vc41_pos 20k
R41_6 N091 Vc41_neg 20k
R42_1 N071 Vc42_pos 20k
R42_6 N092 Vc42_neg 20k
R43_1 N072 Vc43_pos 20k
R43_6 N093 Vc43_neg 20k
R44_1 N073 Vc44_pos 20k
R44_6 N094 Vc44_neg 20k
R45_1 N074 Vc45_pos  20k
R45_6 N095 Vc45_neg 20k
R4_9 N096 Vc4 20k

* Banco 5:
R51_1 N022 Vc51_pos 20k
R51_6 N043 Vc51_neg 20k
R52_1 N023 Vc52_pos 20k
R52_6 N044 Vc52_neg 20k
R53_1 N024 Vc53_pos 20k
R53_6 N045 Vc53_neg 20k
R54_1 N025 Vc54_pos 20k
R54_6 N046 Vc54_neg 20k
R55_1 N026 Vc55_pos  20k
R55_6 N047 Vc55_neg 20k
R5_9 N048 Vc5 20k

* Banco 1:

* Celda 11:
R11_2 out_1 N199 10Meg
R11_3 N199 N210 1Meg
R11_4 N205 N220 49.9k
R11_5 N220 N225 300k
Rout11 out_1 N194 1m
Q11_1 N210 N215 0 0 MMBT2222A
Q11_2 N205 N199 out_1 0 MMBT2907A
Q11_3 N225 N231 0 0 MMBT2222A
XS11 out_neg N220 0 IRLB8721
Vcell11 N194 0 3.3

* Celda 12:
R12_2 out_1 N200 10Meg
R12_3 N200 N211 1Meg
R12_4 N206 N221 49.9k
R12_5 N221 N226 300k
Rout12 out_1 N195 1m
Q12_1 N211 N216 0 0 MMBT2222A
Q12_2 N206 N200 out_1 0 MMBT2907A
Q12_3 N226 N232 0 0 MMBT2222A
XS12 out_neg N221 0 IRLB8721
Vcell12 N195 0 3.3

* Celda 13:
R13_2 out_1 N201 10Meg
R13_3 N201 N212 1Meg
R13_4 N207 N222 49.9k
R13_5 N222 N227 300k
Rout13 out_1 N196 1m
Q13_1 N212 N217 0 0 MMBT2222A
Q13_2 N207 N201 out_1 0 MMBT2907A
Q13_3 N227 N233 0 0 MMBT2222A
XS13 out_neg N222 0 IRLB8721
Vcell13 N196 0 3.3

* Celda 14:
R14_2 out_1 N202 10Meg
R14_3 N202 N213 1Meg
R14_4 N208 N223 49.9k
R14_5 N223 N228 300k
Rout14 out_1 N197 1m
Q14_1 N213 N218 0 0 MMBT2222A
Q14_2 N208 N202 out_1 0 MMBT2907A
Q14_3 N228 N234 0 0 MMBT2222A
XS14 out_neg N223 0 IRLB8721
Vcell14 N197 0 3.3

* Celda 15:
R15_2 out_1 N203 10Meg
R15_3 N203 N214 1Meg
R15_4 N209 N224 49.9k
R15_5 N224 N229 300k
Rout15 out_1 N198 1m
Q15_1 N214 N219 0 0 MMBT2222A
Q15_2 N209 N203 out_1 0 MMBT2907A
Q15_3 N229 N235 0 0 MMBT2222A
XS15 out_neg N224 0 IRLB8721
Vcell15 N198 0 3.3

* Switch bypass 1:
R1_7 out_1 N204 570K
R1_8 N204 N193 300K
Q1_1 N193 N230 0 0 MMBT2222A
* JQ1_2 out_1 N193 N204 MMBFJ201
XS1 out_neg N204 out_1 AO3401A

* Banco 2:

* Celda 21:
R21_2 out_2 N145 10Meg
R21_3 N145 N161 1Meg
R21_4 N156 N176 49.9k
R21_5 N176 N182 300k
Rout21 out_2 N150 1m
Q21_1 N161 N166 0 0 MMBT2222A
Q21_2 N156 N145 out_2 0 MMBT2907A
Q21_3 N182 N187 0 0 MMBT2222A
XS21 out_1 N176 N171 IRLB8721
Vcell21 N150 N171 3.3

* Celda 22:
R22_2 out_2 N146 10Meg
R22_3 N146 N162 1Meg
R22_4 N157 N177 49.9k
R22_5 N177 N183 300k
Rout22 out_2 N151 1m
Q22_1 N162 N167 0 0 MMBT2222A
Q22_2 N157 N146 out_2 0 MMBT2907A
Q22_3 N183 N188 0 0 MMBT2222A
XS22 out_1 N177 N172 IRLB8721
Vcell22 N151 N172 3.3

* Celda 23:
R23_2 out_2 N147 10Meg
R23_3 N147 N163 1Meg
R23_4 N158 N178 49.9k
R23_5 N178 N184 300k
Rout23 out_2 N152 1m
Q23_1 N163 N168 0 0 MMBT2222A
Q23_2 N158 N147 out_2 0 MMBT2907A
Q23_3 N184 N189 0 0 MMBT2222A
XS23 out_1 N178 N173 IRLB8721
Vcell23 N152 N173 3.3

* Celda 24:
R24_2 out_2 N148 10Meg
R24_3 N148 N164 1Meg
R24_4 N159 N179 49.9k
R24_5 N179 N185 300k
Rout24 out_2 N153 1m
Q24_1 N164 N169 0 0 MMBT2222A
Q24_2 N159 N148 out_2 0 MMBT2907A
Q24_3 N185 N190 0 0 MMBT2222A
XS24 out_1 N179 N174 IRLB8721
Vcell24 N153 N174 3.3

* Celda 25:
R25_2 out_2 N149 10Meg
R25_3 N149 N165 1Meg
R25_4 N160 N180 49.9k
R25_5 N180 N186 300k
Rout25 out_2 N154 1m
Q25_1 N165 N170 0 0 MMBT2222A
Q25_2 N160 N149 out_2 0 MMBT2907A
Q25_3 N186 N191 0 0 MMBT2222A
XS25 out_1 N180 N175 IRLB8721
Vcell25 N154 N175 3.3

* Switch bypass 2:
R2_7 out_2 N181 570K
R2_8 N181 N155 300K
Q2_1 N155 N192 0 0 MMBT2222A
* JQ2_2 out_2 N155 N181 MMBFJ201
XS2 out_1 N181 out_2 AO3401A

* Banco 3:

* Celda 31:
R31_2 out_3 N097 10Meg
R31_3 N097 N113 1Meg
R31_4 N108 N128 49.9k
R31_5 N128 N134 300k
Rout31 out_3 N102 1m
Q31_1 N113 N118 0 0 MMBT2222A
Q31_2 N108 N097 out_3 0 MMBT2907A
Q31_3 N134 N139 0 0 MMBT2222A
XS31 out_2 N128 N123 IRLB8721
Vcell31 N102 N123 3.3

* Celda 32:
R32_2 out_3 N098 10Meg
R32_3 N098 N114 1Meg
R32_4 N109 N129 49.9k
R32_5 N129 N135 300k
Rout32 out_3 N103 1m
Q32_1 N114 N119 0 0 MMBT2222A
Q32_2 N109 N098 out_3 0 MMBT2907A
Q32_3 N135 N140 0 0 MMBT2222A
XS32 out_2 N129 N124 IRLB8721
Vcell32 N103 N124 3.3

* Celda 33:
R33_2 out_3 N099 10Meg
R33_3 N099 N115 1Meg
R33_4 N110 N130 49.9k
R33_5 N130 N136 300k
Rout33 out_3 N104 1m
Q33_1 N115 N120 0 0 MMBT2222A
Q33_2 N110 N099 out_3 0 MMBT2907A
Q33_3 N136 N141 0 0 MMBT2222A
XS33 out_2 N130 N125 IRLB8721
Vcell33 N104 N125 3.3

* Celda 34:
R34_2 out_3 N100 10Meg
R34_3 N100 N116 1Meg
R34_4 N111 N131 49.9k
R34_5 N131 N137 300k
Rout34 out_3 N105 1m
Q34_1 N116 N121 0 0 MMBT2222A
Q34_2 N111 N100 out_3 0 MMBT2907A
Q34_3 N137 N142 0 0 MMBT2222A
XS34 out_2 N131 N126 IRLB8721
Vcell34 N105 N126 3.3

* Celda 35:
R35_2 out_3 N101 10Meg
R35_3 N101 N117 1Meg
R35_4 N112 N132 49.9k
R35_5 N132 N138 300k
Rout35 out_3 N106 1m
Q35_1 N117 N122 0 0 MMBT2222A
Q35_2 N112 N101 out_3 0 MMBT2907A
Q35_3 N138 N143 0 0 MMBT2222A
XS35 out_2 N132 N127 IRLB8721
Vcell35 N106 N127 3.3

* Switch bypass 3:
R3_7 out_3 N133 570K
R3_8 N133 N107 300K
Q3_1 N107 N144 0 0 MMBT2222A
* JQ3_2 out_3 N107 N133 MMBFJ201
XS3 out_2 N133 out_3 AO3401A

* Banco 4:

* Celda 41:
R41_2 out_4 N049 10Meg
R41_3 N049 N065 1Meg
R41_4 N060 N080 49.9k
R41_5 N080 N086 300k
Rout41 out_4 N054 1m
Q41_1 N065 N070 0 0 MMBT2222A
Q41_2 N060 N049 out_4 0 MMBT2907A
Q41_3 N086 N091 0 0 MMBT2222A
XS41 out_3 N080 N075 IRLB8721
Vcell41 N054 N075 3.3

* Celda 42:
R42_2 out_4 N050 10Meg
R42_3 N050 N066 1Meg
R42_4 N061 N081 49.9k
R42_5 N081 N087 300k
Rout42 out_4 N055 1m
Q42_1 N066 N071 0 0 MMBT2222A
Q42_2 N061 N050 out_4 0 MMBT2907A
Q42_3 N087 N092 0 0 MMBT2222A
XS42 out_3 N081 N076 IRLB8721
Vcell42 N055 N076 3.3

* Celda 43:
R43_2 out_4 N051 10Meg
R43_3 N051 N067 1Meg
R43_4 N062 N082 49.9k
R43_5 N082 N088 300k
Rout43 out_4 N056 1m
Q43_1 N067 N072 0 0 MMBT2222A
Q43_2 N062 N051 out_4 0 MMBT2907A
Q43_3 N088 N093 0 0 MMBT2222A
XS43 out_3 N082 N077 IRLB8721
Vcell43 N056 N077 3.3

* Celda 44:
R44_2 out_4 N052 10Meg
R44_3 N052 N068 1Meg
R44_4 N063 N083 49.9k
R44_5 N083 N089 300k
Rout44 out_4 N057 1m
Q44_1 N068 N073 0 0 MMBT2222A
Q44_2 N063 N052 out_4 0 MMBT2907A
Q44_3 N089 N094 0 0 MMBT2222A
XS44 out_3 N083 N078 IRLB8721
Vcell44 N057 N078 3.3

* Celda 45:
R45_2 out_4 N053 10Meg
R45_3 N053 N069 1Meg
R45_4 N064 N084 49.9k
R45_5 N084 N090 300k
Rout45 out_4 N058 1m
Q45_1 N069 N074 0 0 MMBT2222A
Q45_2 N064 N053 out_4 0 MMBT2907A
Q45_3 N090 N095 0 0 MMBT2222A
XS45 out_3 N084 N079 IRLB8721
Vcell45 N058 N079 3.3

* Switch bypass 4:
R4_7 out_4 N085 570K
R4_8 N085 N059 300K
Q4_1 N059 N096 0 0 MMBT2222A
* JQ4_2 out_4 N059 N085 MMBFJ201
XS4 out_3 N085 out_4 AO3401A

* Banco 5:

* Celda 51:
R51_2 out_pos N001 10Meg
R51_3 N001 N017 1Meg
R51_4 N012 N032 49.9k
R51_5 N032 N038 300k
Rout51 out_pos N006 1m
Q51_1 N017 N022 0 0 MMBT2222A
Q51_2 N012 N001 out_pos 0 MMBT2907A
Q51_3 N038 N043 0 0 MMBT2222A
XS51 out_4 N032 N027 IRLB8721
Vcell51 N006 N027 3.3

* Celda 52:
R52_2 out_pos N002 10Meg
R52_3 N002 N018 1Meg
R52_4 N013 N033 49.9k
R52_5 N033 N039 300k
Rout52 out_pos N007 1m
Q52_1 N018 N023 0 0 MMBT2222A
Q52_2 N013 N002 out_pos 0 MMBT2907A
Q52_3 N039 N044 0 0 MMBT2222A
XS52 out_4 N033 N028 IRLB8721
Vcell52 N007 N028 3.3

* Celda 53:
R53_2 out_pos N003 10Meg
R53_3 N003 N019 1Meg
R53_4 N014 N034 49.9k
R53_5 N034 N040 300k
Rout53 out_pos N008 1m
Q53_1 N019 N024 0 0 MMBT2222A
Q53_2 N014 N003 out_pos 0 MMBT2907A
Q53_3 N040 N045 0 0 MMBT2222A
XS53 out_4 N034 N029 IRLB8721
Vcell53 N008 N029 3.3

* Celda 54:
R54_2 out_pos N004 10Meg
R54_3 N004 N020 1Meg
R54_4 N015 N035 49.9k
R54_5 N035 N041 300k
Rout54 out_pos N009 1m
Q54_1 N020 N025 0 0 MMBT2222A
Q54_2 N015 N004 out_pos 0 MMBT2907A
Q54_3 N041 N046 0 0 MMBT2222A
XS54 out_4 N035 N030 IRLB8721
Vcell54 N009 N030 3.3

* Celda 55:
R55_2 out_pos N005 10Meg
R55_3 N005 N021 1Meg
R55_4 N016 N036 49.9k
R55_5 N036 N042 300k
Rout55 out_pos N010 1m
Q55_1 N021 N026 0 0 MMBT2222A
Q55_2 N016 N005 out_pos 0 MMBT2907A
Q55_3 N042 N047 0 0 MMBT2222A
XS55 out_4 N036 N031 IRLB8721
Vcell55 N010 N031 3.3

* Switch bypass 5:
R5_7 out_pos N037 570K
R5_8 N037 N011 300K
Q5_1 N011 N048 0 0 MMBT2222A
* JQ5_2 out_pos N011 N037 MMBFJ201
XS5 out_4 N037 out_pos AO3401A

* Salida:
RL out_pos out_neg 1k

* Características del análisis:
.tran 10u 40m
.print tran V(out_pos, out_neg)

.end

* === Fuentes de control din�micas ===
Vcontrol11 ctrl11 0 PWL(0.000000 5 0.009999 5 0.010000 5 0.019999 5 0.020000 0 0.029999 0 0.030000 0 0.039999 0)
Vcontrol12 ctrl12 0 PWL(0.000000 0 0.009999 0 0.010000 5 0.019999 5 0.020000 5 0.029999 5 0.030000 0 0.039999 0)
Vcontrol13 ctrl13 0 PWL(0.000000 0 0.009999 0 0.010000 0 0.019999 0 0.020000 0 0.029999 0 0.030000 0 0.039999 0)
Vcontrol14 ctrl14 0 PWL(0.000000 0 0.009999 0 0.010000 0 0.019999 0 0.020000 0 0.029999 0 0.030000 0 0.039999 0)
Vcontrol15 ctrl15 0 PWL(0.000000 0 0.009999 0 0.010000 0 0.019999 0 0.020000 0 0.029999 0 0.030000 0 0.039999 0)
Vcontrol21 ctrl21 0 PWL(0.000000 0 0.009999 0 0.010000 0 0.019999 0 0.020000 0 0.029999 0 0.030000 0 0.039999 0)
Vcontrol22 ctrl22 0 PWL(0.000000 0 0.009999 0 0.010000 0 0.019999 0 0.020000 0 0.029999 0 0.030000 0 0.039999 0)
Vcontrol23 ctrl23 0 PWL(0.000000 0 0.009999 0 0.010000 0 0.019999 0 0.020000 0 0.029999 0 0.030000 0 0.039999 0)
Vcontrol24 ctrl24 0 PWL(0.000000 0 0.009999 0 0.010000 0 0.019999 0 0.020000 0 0.029999 0 0.030000 0 0.039999 0)
Vcontrol25 ctrl25 0 PWL(0.000000 0 0.009999 0 0.010000 0 0.019999 0 0.020000 0 0.029999 0 0.030000 0 0.039999 0)
Vcontrol31 ctrl31 0 PWL(0.000000 0 0.009999 0 0.010000 0 0.019999 0 0.020000 0 0.029999 0 0.030000 0 0.039999 0)
Vcontrol32 ctrl32 0 PWL(0.000000 0 0.009999 0 0.010000 0 0.019999 0 0.020000 0 0.029999 0 0.030000 0 0.039999 0)
Vcontrol33 ctrl33 0 PWL(0.000000 0 0.009999 0 0.010000 0 0.019999 0 0.020000 5 0.029999 5 0.030000 5 0.039999 5)
Vcontrol34 ctrl34 0 PWL(0.000000 0 0.009999 0 0.010000 0 0.019999 0 0.020000 0 0.029999 0 0.030000 0 0.039999 0)
Vcontrol35 ctrl35 0 PWL(0.000000 0 0.009999 0 0.010000 0 0.019999 0 0.020000 0 0.029999 0 0.030000 0 0.039999 0)
Vcontrol41 ctrl41 0 PWL(0.000000 0 0.009999 0 0.010000 0 0.019999 0 0.020000 0 0.029999 0 0.030000 0 0.039999 0)
Vcontrol42 ctrl42 0 PWL(0.000000 0 0.009999 0 0.010000 0 0.019999 0 0.020000 0 0.029999 0 0.030000 0 0.039999 0)
Vcontrol43 ctrl43 0 PWL(0.000000 0 0.009999 0 0.010000 0 0.019999 0 0.020000 0 0.029999 0 0.030000 0 0.039999 0)
Vcontrol44 ctrl44 0 PWL(0.000000 0 0.009999 0 0.010000 0 0.019999 0 0.020000 0 0.029999 0 0.030000 5 0.039999 5)
Vcontrol45 ctrl45 0 PWL(0.000000 0 0.009999 0 0.010000 0 0.019999 0 0.020000 0 0.029999 0 0.030000 0 0.039999 0)
Vcontrol51 ctrl51 0 PWL(0.000000 0 0.009999 0 0.010000 0 0.019999 0 0.020000 0 0.029999 0 0.030000 0 0.039999 0)
Vcontrol52 ctrl52 0 PWL(0.000000 0 0.009999 0 0.010000 0 0.019999 0 0.020000 0 0.029999 0 0.030000 0 0.039999 0)
Vcontrol53 ctrl53 0 PWL(0.000000 0 0.009999 0 0.010000 0 0.019999 0 0.020000 0 0.029999 0 0.030000 0 0.039999 0)
Vcontrol54 ctrl54 0 PWL(0.000000 0 0.009999 0 0.010000 0 0.019999 0 0.020000 0 0.029999 0 0.030000 0 0.039999 0)
Vcontrol55 ctrl55 0 PWL(0.000000 0 0.009999 0 0.010000 0 0.019999 0 0.020000 0 0.029999 0 0.030000 5 0.039999 5)

.tran 10u 40m
